; Load order for DiffAmpPcell_T28 split package.

load("D:/OpenCodePrj/prj1-SkillCoding/Result/DiffAmpPcell_T28_split/00_dft28_common.il")
load("D:/OpenCodePrj/prj1-SkillCoding/Result/DiffAmpPcell_T28_split/01_dft28_core_geometry.il")
load("D:/OpenCodePrj/prj1-SkillCoding/Result/DiffAmpPcell_T28_split/02_dft28_define_pcells.il")

printf("DFT28 split package loaded. Run DFT28_defineAllPcells(\"yourLib\")\n")
